** Profile: "SCHEMATIC1-Question_2"  [ C:\Users\Amirreza\Documents\Term3\EC\question2-SCHEMATIC1-Question_2.sim ]

** Creating circuit file "question2-SCHEMATIC1-Question_2.sim.cir"
** WARNING: THIS AUTOMATICALLY GENERATED FILE MAY BE OVERWRITTEN BY SUBSEQUENT SIMULATIONS

*Libraries:
* Local Libraries :
* From [PSPICE NETLIST] section of C:\Program Files\Orcad\PSpice\PSpice.ini file:
.lib "nom.lib"

*Analysis directives:
.PROBE V(*) I(*) W(*) D(*) NOISE(*)
.INC ".\question2-SCHEMATIC1.net"

.END
