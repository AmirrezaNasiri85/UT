** Profile: "SCHEMATIC1-1"  [ C:\Users\Amirreza\Documents\Term3\EC\ca1-SCHEMATIC1-1.sim ]

** Creating circuit file "ca1-SCHEMATIC1-1.sim.cir"
** WARNING: THIS AUTOMATICALLY GENERATED FILE MAY BE OVERWRITTEN BY SUBSEQUENT SIMULATIONS

*Libraries:
* Local Libraries :
* From [PSPICE NETLIST] section of C:\Program Files\Orcad\PSpice\PSpice.ini file:
.lib "nom.lib"

*Analysis directives:
.PROBE V(*) I(*) W(*) D(*) NOISE(*)
.INC ".\ca1-SCHEMATIC1.net"

.END
